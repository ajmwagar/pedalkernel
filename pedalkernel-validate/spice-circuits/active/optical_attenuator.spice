* ============================================================================
* Optical Attenuator - VTL5C3 Photocoupler
* PedalKernel Validation Circuit
* ============================================================================
* Variable attenuator using light-dependent resistor (LDR).
* VTL5C3 Vactrol: LED current controls LDR resistance.
* Dark resistance ~1M, lit resistance ~1.5k.
* This test uses no LED drive (default dark state, R_ldr = 1M).
* ============================================================================

* Supply voltage
Vcc vcc 0 DC 9

* Input coupling capacitor
C_in v_in vin_ac 100n

* Top of voltage divider
R_top vin_ac vdiv 10k

* LDR in dark state (no LED drive) = 1M ohm
R_ldr vdiv 0 1000k

* Output coupling
C_out vdiv vout_ac 100n
R_out vout_ac 0 10k

* Output node
Eout v_out 0 vout_ac 0 1
