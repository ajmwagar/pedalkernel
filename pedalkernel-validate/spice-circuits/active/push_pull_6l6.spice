* ============================================================================
* Push-Pull 6L6GC Output Stage — True Center-Tapped Transformer Topology
* PedalKernel Validation Circuit
* ============================================================================
* Class AB pentode power amplifier with push-pull topology.
* Two 6L6GC beam tetrodes driving a center-tapped output transformer.
*
* Transformer model derived from GENERIC_10K_10K entry in transformers.model:
*   LP=10H  K=0.995  RP=500  RS=500  LLP=50m  LLS=50m  LM=9.95  RC=1MEG
* Scaled for push-pull half-primaries (2.5H each, two in series = 5H/side):
*   L_p1 = L_p2 = 2.5H   each plate to center-tap (B+)
*   K_pp = 0.999           bifilar-wound halves; K slightly tighter than single-winding
*   Rp1  = Rp2  = 125      DC winding resistance per half (500 Ohm / 4)
*   Llk_p1 = Llk_p2 = 12.5m  leakage per half (50m / 4)
* Secondary for 25:1 plate-to-plate turns ratio:
*   N_s/N_half = 2/25  =>  L_s = 2.5 * (2/25)^2 = 16mH
*   Rs  = 2             secondary DC resistance
*   Llk_s = 0.1m        secondary leakage
*
* Topology matches .pedal:
*   V1.plate -> T1.a  (half-primary A, node vp1)
*   V2.plate -> T1.b  (half-primary B, node vp2)
*   T1.ct           -> B+ (vb, via 0V monitor source Vct)
*   T1.c            -> v_out (secondary top, to RL)
*   T1.d            -> gnd   (secondary bottom)
* ============================================================================

* B+ supply (typical for 6L6 output stage, matches pedal supply 400V)
VB vb 0 DC 400

* Input coupling capacitors
C1 v_in vg1 22n IC=0
C2 0    vg2 22n IC=0

* Grid leak resistors
Rg1 vg1 0 220k
Rg2 vg2 0 220k

* Shared cathode bias (both tubes share one cathode resistor to ground)
Rk  vk  0 250
Ck  vk  0 100u IC=25

* Screen grid supply resistors (from B+)
Rsg1 vb vsg1 1k
Rsg2 vb vsg2 1k

* Screen bypass — both screen nodes tied together at the bypass cap.
* Matches .pedal: Rsg1.b -> V1.g2, Csg.a  and  Rsg2.b -> V2.g2, Csg.a
* The cap bridges vsg1 and vsg2, keeping both screens AC-grounded together.
Csg  vsg1 vsg2 47u IC=0
* Tie lower end of the bypass network to ground (Csg.b -> gnd in pedal)
Rcsg vsg2 0 1Meg

* ============================================================================
* Output transformer — center-tapped push-pull primary + separate secondary
* ============================================================================

* --- Primary half A: V1 plate (vp1) --> center-tap (vct) ---
Llk_p1  vp1    vp1_lk 12.5m IC=0.05
Rp1     vp1_lk vp1_m  125
Lp1     vp1_m  vct    2.5   IC=0.05

* Convergence snubber: 50kOhm across primary half A.
* This is ~20x the plate impedance (2.5k) — negligible effect on signal
* frequencies but prevents dV/dt blow-up at UIC startup with zero inductor IC.
Rsnub1  vp1    vct    50k

* --- Primary half B: V2 plate (vp2) --> center-tap (vct) ---
Llk_p2  vp2    vp2_lk 12.5m IC=0.05
Rp2     vp2_lk vp2_m  125
Lp2     vp2_m  vct    2.5   IC=0.05

* Convergence snubber across primary half B (same rationale as Rsnub1)
Rsnub2  vp2    vct    50k

* Center-tap connected to B+; 0V source monitors CT current
Vct vct vb DC 0

* Mutual coupling between the two half-primaries
K_pp Lp1 Lp2 0.999

* --- Secondary winding (L_s = 16mH for 25:1 plate-to-plate ratio) ---
Llk_s  vs_hi  vs_m   0.1m IC=0
Rs     vs_m   vs_lo  2
Ls     vs_lo  vs_gnd 16m  IC=0

* Secondary return node connected to circuit ground
Vs_gnd vs_gnd 0 DC 0

* Mutual coupling: secondary to each primary half
K_s1 Lp1 Ls 0.999
K_s2 Lp2 Ls 0.999

* ============================================================================
* Output load — speaker (8 Ohm), matches .pedal RL
* v_out = T1.c (secondary top); vs_gnd = T1.d (secondary bottom = gnd)
* ============================================================================
Rout vs_hi v_out 1
RL   v_out 0     8

* Initial conditions: approximate class AB DC operating point.
* Cathode bias: Vk ≈ (Ik1 + Ik2) * Rk = 2 * 50mA * 250 = 25V
* Screen voltages: B+ minus small drop through Rsg
* Plate voltages: approximately B+ - Vk - transformer copper drop ≈ 350V
.IC V(vk)=25 V(vg1)=0 V(vg2)=0 V(vsg1)=395 V(vsg2)=395
.IC V(vp1)=350 V(vp1_lk)=350 V(vp1_m)=350
.IC V(vp2)=350 V(vp2_lk)=350 V(vp2_m)=350
.IC V(vct)=400

* DELMAX limits the adaptive timestep to a fraction of the fastest signal
* period (440Hz -> T = 2.27ms; DELMAX = T/40 ~= 57us gives ~40 steps/cycle).
* This is much coarser than the output timestep (2.6us) but ngspice still
* outputs at the requested 2.6us intervals via interpolation.  The harness
* resamples the SPICE output onto the uniform grid regardless.
* Without DELMAX the inductor stiffness forces tiny adaptive steps (>5 min).
.OPTIONS DELMAX=57e-6

* ============================================================================
* 6L6GC Pentode subcircuits
* ============================================================================
XV1 vp1 vg1 vsg1 vk PENTODE_6L6GC
XV2 vp2 vg2 vsg2 vk PENTODE_6L6GC

* ============================================================================
* 6L6GC Pentode Model — Koren-style beam tetrode equations
* Parameters from typical 6L6GC datasheet curves (unchanged).
* Screen handling: screen current flows from g2 through Rsg to B+.
* NOTE (topology-only scope): the Koren model does not capture beam-tetrode
* kink or screen-current redistribution at high Va. That is a model accuracy
* issue, not a topology issue, and is out of scope per bead instructions.
* ============================================================================
.SUBCKT PENTODE_6L6GC anode g1 g2 cathode
.PARAM MU=8.7 EX=1.35 KG1=1460 KP=48 KVB=12 KG2=4500

* Internal voltage references
Bvg1 vg1_int 0 V = V(g1,cathode)
Bvg2 vg2_int 0 V = V(g2,cathode)
Bva  va_int  0 V = V(anode,cathode)

* Plate current
Bip anode cathode I = MAX(0, PWR(LOG(1 + EXP(KP * (1/MU + V(vg1_int)/SQRT(KVB + PWR(V(vg2_int),2))))) * V(vg2_int) / KP, EX) / KG1 * TANH(V(va_int)/15))

* Screen current (approximately 20% of plate current for beam tetrode)
Big2 g2 cathode I = MAX(0, PWR(LOG(1 + EXP(KP * (1/MU + V(vg1_int)/SQRT(KVB + PWR(V(vg2_int),2))))) * V(vg2_int) / KP, EX) / KG2)

* Grid current (when grid goes positive)
Dg1 g1 cathode DGRID
.MODEL DGRID D(IS=1e-12 N=1.5 RS=1k)

.ENDS PENTODE_6L6GC
