* ============================================================================
* Push-Pull 6L6GC Output Stage — True Center-Tapped Transformer Topology
* PedalKernel Validation Circuit
* ============================================================================
* Class AB pentode power amplifier with push-pull topology.
* Two 6L6GC beam tetrodes driving a center-tapped output transformer.
*
* Transformer model derived from GENERIC_10K_10K entry in transformers.model:
*   LP=10H  K=0.995  RP=500  RS=500  LLP=50m  LLS=50m  LM=9.95  RC=1MEG
* Scaled for push-pull half-primaries (2.5H each, two in series = 5H/side):
*   L_p1 = L_p2 = 2.5H   each plate to center-tap (B+)
*   K_pp = 0.999           bifilar-wound halves
*   Rp1  = Rp2  = 125      DC winding resistance per half (500 Ohm / 4)
*   Llk_p1 = Llk_p2 = 12.5m  leakage per half (50m / 4)
* Secondary for 25:1 plate-to-plate turns ratio:
*   N_s/N_half = 2/25  =>  L_s = 2.5 * (2/25)^2 = 16mH
*   Rs  = 2             secondary DC resistance
*   Llk_s = 0.1m        secondary leakage
*
* Transformer winding convention (critical for correct push-pull polarity):
*   Lp1 defined as  vp1_m → vct  (dot at vp1_m, plate side)
*   Lp2 defined as  vct  → vp2_m  (dot at vct, REVERSED winding direction)
*   This reversal ensures that when V1 draws more current AND V2 draws less,
*   both induce EMF in the SAME direction in Ls → additive push-pull action.
*   Without the reversal the two half-primaries cancel fundamental in Ls.
*
* Push-pull drive: V1 receives v_in (harness source); Einv mirrors −v_in to
* V2 grid, providing true differential drive and even-harmonic cancellation.
*
* Convergence strategy for stiff inductive circuits:
*   - Large parallel damping resistors (100k–500kΩ) on every inductor
*     break the numerical stiffness without affecting signal-frequency
*     behaviour (LC corner for 2.5H||500kΩ is ~32Hz, well below 440Hz)
*   - Snubber resistors (50kΩ) across primary halves limit dV/dt at startup
*   - Explicit .IC on every reactive element seeds the DC operating point
*   - DELMAX=57e-6 limits the adaptive step to T/40 at 440Hz
*   - METHOD=GEAR (A-stable) avoids trapezoidal oscillation on stiff meshes
*   These settings survive the harness's .OPTIONS injection because DELMAX
*   is not overridden by the harness (it sets RELTOL/ABSTOL/VNTOL only).
* ============================================================================

* B+ supply (matches pedal supply 400V)
VB vb 0 DC 400

* ============================================================================
* Phase-inverted drive for V2 grid.
* Einv provides -v_in so both grids see differential (push-pull) signals.
* The harness injects its PWL signal at v_in; Einv derives anti-phase
* automatically — no harness changes needed.
* ============================================================================
Einv v_in_inv 0 v_in 0 -1

* Input coupling capacitors
* C1: v_in -> V1 grid (push phase)
* C2: v_in_inv -> V2 grid (pull phase, inverted)
C1 v_in     vg1 22n IC=0
C2 v_in_inv vg2 22n IC=0

* Grid leak resistors (provide DC path for grid self-bias)
Rg1 vg1 0 220k
Rg2 vg2 0 220k

* Shared cathode bias (both tubes share one cathode resistor)
Rk  vk  0 250
Ck  vk  0 100u IC=25

* Screen grid supply resistors (from B+)
Rsg1 vb vsg1 1k
Rsg2 vb vsg2 1k

* Screen bypass — both screen nodes tied at the bypass cap.
Csg  vsg1 vsg2 47u IC=0
* Bleed resistor anchors lower end of bypass network to ground
Rcsg vsg2 0 1Meg

* ============================================================================
* Output transformer — center-tapped push-pull primary + separate secondary
* ============================================================================

* --- Primary half A: V1 plate (vp1) --> center-tap (vct) ---
Llk_p1  vp1    vp1_lk 12.5m IC=0.05
* Parallel damping: fc = R/(2π×L) = 100k/(2π×12.5m) ≈ 1.27MHz — no signal effect
Rdlk1   vp1    vp1_lk 100k
Rp1     vp1_lk vp1_m  125
* Lp1: dot at vp1_m (toward V1 plate)
Lp1     vp1_m  vct    2.5   IC=0.05
* Parallel damping: fc = 500k/(2π×2.5) ≈ 32kHz — above signal, below inductor LF knee
Rdp1    vp1_m  vct    500k
* Convergence snubber: ~20x plate impedance (2.5k), negligible at signal frequencies
Rsnub1  vp1    vct    50k

* --- Primary half B: V2 plate (vp2) --> center-tap (vct) ---
Llk_p2  vp2    vp2_lk 12.5m IC=0.05
Rdlk2   vp2    vp2_lk 100k
Rp2     vp2_lk vp2_m  125
* Lp2: REVERSED winding — dot at vct (center-tap side).
* Reversal is required for correct push-pull OT topology: when V2 current
* decreases (pull), effective current into dot increases, inducing additive
* EMF in Ls alongside Lp1's contribution. Without reversal, the two halves
* cancel each other in the secondary (all fundamental is lost).
Lp2     vct    vp2_m  2.5   IC=-0.05
Rdp2    vp2_m  vct    500k
Rsnub2  vp2    vct    50k

* Center-tap connected to B+; 0V monitor source for CT current
Vct vct vb DC 0

* Mutual coupling between the two half-primaries (bifilar wound)
K_pp Lp1 Lp2 0.999

* --- Secondary winding (L_s = 16mH for 25:1 plate-to-plate ratio) ---
Llk_s  vs_hi  vs_m   0.1m IC=0
Rdlk_s vs_hi  vs_m   100k
Rs     vs_m   vs_lo  2
Ls     vs_lo  vs_gnd 16m  IC=0
Rdls   vs_lo  vs_gnd 500k

* Secondary return connected to circuit ground
Vs_gnd vs_gnd 0 DC 0

* Mutual coupling: secondary to each primary half (both same polarity with Lp2 reversed)
K_s1 Lp1 Ls 0.999
K_s2 Lp2 Ls 0.999

* ============================================================================
* Output load — speaker (8 Ohm), matches .pedal RL
* ============================================================================
Rout vs_hi v_out 1
RL   v_out 0     8

* ============================================================================
* Initial conditions: approximate class AB DC operating point.
* Cathode bias: Vk ≈ (Ik1 + Ik2) × Rk = 2 × 50mA × 250 = 25V
* Screen voltages: B+ minus small drop through Rsg (≈395V)
* Plate voltages: B+ − Vk − transformer copper drop ≈ 350V
* Grids at 0V → Vg1k = 0 − 25 = −25V (class AB bias)
* ============================================================================
.IC V(vk)=25 V(vg1)=0 V(vg2)=0 V(vsg1)=395 V(vsg2)=395
.IC V(vp1)=350 V(vp1_lk)=350 V(vp1_m)=350
.IC V(vp2)=350 V(vp2_lk)=350 V(vp2_m)=350
.IC V(vct)=400

* ============================================================================
* Convergence options — stiff-deck recipe for inductive tube circuits.
*
* RELTOL: The harness overrides this with 1e-6; setting it here for
*   standalone verification (the harness appends its .OPTIONS after the
*   circuit body, so its value takes precedence).
* METHOD=GEAR MAXORD=2: A-stable, avoids trapezoidal oscillation on stiff
*   inductor meshes. Not overridden by the harness.
* DELMAX=57e-6: Limits adaptive timestep to ~T/40 at 440Hz. Not set by the
*   harness, so this deck value is respected even inside the harness run.
*   Without DELMAX the stiff inductors force infinitesimally small steps.
* ITL4=100: Raised inner iteration limit for the large nonlinear system.
* ============================================================================
.OPTIONS RELTOL=5e-3 ABSTOL=1e-9 VNTOL=1e-6
.OPTIONS METHOD=GEAR MAXORD=2
.OPTIONS ITL1=500 ITL2=200 ITL4=100
.OPTIONS DELMAX=57e-6

* ============================================================================
* 6L6GC Pentode subcircuits
* ============================================================================
XV1 vp1 vg1 vsg1 vk PENTODE_6L6GC
XV2 vp2 vg2 vsg2 vk PENTODE_6L6GC

* ============================================================================
* 6L6GC Pentode Model — Koren screen-referenced ATAN equation.
*
* Parameters exactly match pedalkernel/models/pentodes.model entry "6L6GC":
*   MU=8.7  EX=1.35  KG1=1460  KG2=4500  KP=48  KVB=12
*
* Plate current formula (matching pedalkernel-rt pentode.rs plate_current()):
*   E1      = KP × (1/MU + Vg1k / Vg2k)
*   base    = (Vg2k / KP) × ln(1 + exp(E1))
*   ip_base = base ^ EX
*   Ip      = (ip_base / KG1) × atan(Vpk / KVB)
*
* Guard conditions:
*   MAX(V(vg2_int), 1): prevents division by zero if screen falls below 1V
*   MAX(V(va_int), 0.001): ATAN argument clipped to positive domain only;
*     plate current is zero for Vpk ≤ 0 (physical cutoff)
*
* Screen current uses the same base expression scaled by KG2 (no ATAN term;
* screen current has softer voltage dependence than plate current).
* ============================================================================
.SUBCKT PENTODE_6L6GC anode g1 g2 cathode
.PARAM MU=8.7 EX=1.35 KG1=1460 KP=48 KVB=12 KG2=4500

* Internal cathode-referenced voltages
Bvg1 vg1_int 0 V = V(g1,cathode)
Bvg2 vg2_int 0 V = V(g2,cathode)
Bva  va_int  0 V = V(anode,cathode)

* Plate current — Koren pentode ATAN form (matches engine exactly)
Bip anode cathode I = {
+ MAX(0,
+   PWR(
+     LOG(1 + EXP(KP * (1/MU + V(vg1_int) / MAX(V(vg2_int), 1))))
+     * MAX(V(vg2_int), 1) / KP,
+   EX)
+   / KG1
+   * ATAN(MAX(V(va_int), 0.001) / KVB)
+ )}

* Screen current (~20% of plate current for beam tetrode)
Big2 g2 cathode I = {
+ MAX(0,
+   PWR(
+     LOG(1 + EXP(KP * (1/MU + V(vg1_int) / MAX(V(vg2_int), 1))))
+     * MAX(V(vg2_int), 1) / KP,
+   EX)
+   / KG2
+ )}

* Grid current (diode conduction when grid goes positive)
Dg1 g1 cathode DGRID
.MODEL DGRID D(IS=1e-12 N=1.5 RS=1k)

.ENDS PENTODE_6L6GC
