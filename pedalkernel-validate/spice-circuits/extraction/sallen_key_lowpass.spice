* Unity-gain Sallen-Key low-pass filter.

R1 v_in n1 10k
R2 n1 v_pos 10k
C1 n1 v_op 10n
C2 v_pos 0 10n
Rout v_op v_out 1k

* Ideal unity buffer.
Eop v_op 0 v_pos v_op 100000
