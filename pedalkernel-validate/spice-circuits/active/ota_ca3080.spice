* ============================================================================
* OTA Voltage-Controlled Amplifier — CA3080 (Single Supply)
* PedalKernel Validation Circuit
* ============================================================================
* Simplified OTA as a VCA with single 9V supply.
* Models CA3080 tanh transconductance: Iout = Iabc * tanh((V+)-(V-)) / (2*Vt))
*
* Small-signal Gm = Iabc / (2*Vt)
* Iabc = Gm * 2 * Vt = 0.002 * 2 * 0.026 = 104uA (rounded to 100uA)
* Saturation onset: differential ~2*Vt = 52mV; fully clipped beyond ~150mV
* ============================================================================

* Bias current (sets Gm = Iabc/(2*Vt) = 104uA/52mV = 2.000mS — exact match to old Gota)
.param Iabc=104u

* Input coupling
C1 v_in inp 100n
Rbias inp 0 100k

* Inverting input to ground
Rinv inn 0 100k

* Supply
VCC vcc 0 DC 9

* OTA modeled as tanh behavioral current source (CA3080 soft-clip)
* Small-signal: Iout ≈ Iabc/(2*Vt) * Vdiff = 2.000mS * Vdiff (matches old Gota 2mS)
* Large-signal: Iout → ±Iabc = ±104uA (saturates beyond ~±52mV differential)
Bota out 0 I = Iabc * tanh( (V(inp) - V(inn)) / (2 * 0.026) )

* Output load resistor
Rload out 0 10k

* Output coupling
C2 out v_out 10u
RL v_out 0 10k
