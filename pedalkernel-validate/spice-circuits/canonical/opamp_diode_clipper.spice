* ============================================================================
* Op-Amp Feedback Diode Clipper (Canonical)
* PedalKernel Validation Circuit — Op-amp + NR in feedback test
* ============================================================================
* R_in = 10k, R_fb = 100k, gain = -10 (limited by diode clipping)
* D_pair = anti-parallel silicon diodes in feedback
* At 50mV input — linear region (expect gain ≈ -10 → ±500mV pk output)
* At 500mV input — diode clipping at ≈ ±0.6V
* ============================================================================
* DC convention: AC-centered (no bias offset).  Matches the WDF model output.
* The previous deck routed Eop v_pos to a 4.5V Vcc/2 bias rail, which caused
* the VCVS to settle at 4.5V DC and produce near-zero AC swing (≈46mV pk-pk
* instead of ≈1000mV pk-pk for the linear case).  This version uses a
* ground-referenced ideal op-amp (v_pos = 0) so that output is AC-centered,
* matching the WDF engine's AC output convention for apples-to-apples
* comparison.  The bias network (Vcc, R_bias1, R_bias2) is removed because
* it served only to supply v_bias for the broken VCVS reference.
* ============================================================================

* Input resistor
R_in v_in v_neg 10k

* Feedback network
R_fb v_neg v_opamp_out 100k

* Anti-parallel diodes in feedback
D1 v_neg v_opamp_out D1N4148
D2 v_opamp_out v_neg D1N4148
.MODEL D1N4148 D(IS=2.52e-9 RS=0.568 N=1.752 BV=100 IBV=100u CJO=4p M=0.4 TT=20n)

* Ideal op-amp as VCVS (inverting config: v_pos = 0, AC-centered)
Eop v_opamp_out 0 0 v_neg 100000

* Output load
RL v_opamp_out v_out 1m
Rload v_out 0 10k
