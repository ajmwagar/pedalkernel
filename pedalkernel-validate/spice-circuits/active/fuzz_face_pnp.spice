* ============================================================================
* Fuzz Face PNP - Germanium Two-Transistor Fuzz
* PedalKernel Validation Circuit
* ============================================================================
* Classic Arbiter Fuzz Face topology with AC128 PNP germanium transistors.
* Q1: Common emitter with collector feedback to Q2 base
* Q2: Common emitter gain stage with output coupling
* PNP transistors: emitters to Vcc, collectors toward ground
* ============================================================================

* Supply voltage
Vcc vcc 0 DC 9

* Input coupling capacitor
C1 v_in net2 2.2u

* Bias resistor (R1 from ground to Vcc sets bias network)
R1 0 vcc 33k

* Q1 base to Q2 collector feedback resistor
R2 net6 net2 8.2k

* Q1 emitter resistor (to Vcc)
R3 vcc net8 470

* Q1 collector to Q2 base bias resistor
R4 net4 net7 100k

* First PNP transistor Q1 (AC128)
* Collector at net4, base at net2, emitter at vcc
Q1 net4 net2 vcc QAC128

* Second PNP transistor Q2 (AC128)
* Collector at net6, base at net7, emitter at net8
Q2 net6 net7 net8 QAC128

* Output coupling capacitor
C2 net6 v_out 10u

* Load resistor
RL v_out 0 10k

* AC128 PNP Germanium transistor model
* DAFx-2017 vintage-extracted, audio-validated AC128 (Holmes/Holters/van Walstijn).
* Source: https://www.dafx17.eca.ed.ac.uk/papers/DAFx17_paper_28.pdf
*         https://github.com/grwhitehead/germaniumbjts
* Parameters MATCH pedalkernel/models/transistors.model .MODEL AC128 exactly so the WDF
* and this ngspice golden use identical devices. (The previous tuned IS=2.5u model biased
* Q2 dead/floating.)
.MODEL QAC128 PNP(IS=20.66u BF=229.6 BR=14.66 NF=1.133 NR=1.140 VAF=19.68 VAR=88.28
+                 IKF=463m IKR=241.5m ISE=2.190u ISC=7.546u NE=1.796 NC=1.364
+                 RB=1.885 RE=306.4m RC=1.727u
+                 CJE=100p VJE=0.3 MJE=0.5 CJC=100p VJC=0.3 MJC=0.5
+                 TF=1n TR=100n)
