* ============================================================================
* XREF Single-BJT collector->base shunt-feedback amplifier (2N3904)
* PedalKernel Cross-Reference Experiment (pedalkernel-0c2p) — bonus path test
* ============================================================================
* Faithful to circuits/active/xref_single_bjt_fb.spice's pedal twin.
* Rf from collector(out) -> base both biases AND closes the feedback loop;
* Cf across Rf is the reactive port in the loop. +24 V rail.
* ============================================================================
VCC   vcc   0     DC 24

Cin   v_in  ni    10u
Rin   ni    nb1   2.2k

Rf    nout  nb1   RF_VALUE
Cf    nout  nb1   CF_VALUE

RC1   vcc   nout  4.7k
Q1    nout  nb1   ne1   2N3904
RE1   ne1   0     470
CE1   ne1   0     220u

Cout  nout  v_out 10u
RL    v_out 0     10k

.MODEL 2N3904 NPN(IS=6.734f BF=416.4 BR=0.7371 NF=1.0 NR=1.0 VAF=74.03 VAR=28.0
+ IKF=66.78m IKR=10m ISE=6.734f NE=1.259 ISC=0 NC=2.0 RB=10 RE=0.1 RC=1
+ CJE=4.493p VJE=0.7 MJE=0.2593 CJC=3.638p VJC=0.75 MJC=0.2593 TF=301.2p TR=24n)
