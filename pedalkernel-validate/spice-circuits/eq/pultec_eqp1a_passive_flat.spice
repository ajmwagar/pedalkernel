* ============================================================================
* Pultec EQP-1A — Passive EQ section, FLAT configuration
* PedalKernel Validation Circuit (bead pedalkernel-hcpb.1)
* ============================================================================
*
* Mirrors pultec_eqp1a_passive.pedal exactly.
*
* Pot model: WdfPot rp = taper.apply(pos) * max_R, min = max_R * 0.001
*   Audio taper (A): taper.apply(p) = (10^p - 1) / 9
*   Linear taper (B): taper.apply(p) = p
*   Minimum resistance floor: max_R * 0.001 = 10k * 0.001 = 10Ω
*
* Control positions (FLAT — all EQ off, default 0.0 except HF_BW=0.5):
*   LF_Boost = 0.0  → rp = (10^0-1)/9 * 10k = 0 → floored at 10Ω
*   LF_Atten = 0.0  → rp = 10Ω
*   HF_Boost = 0.0  → rp = 10Ω
*   HF_BW    = 0.5  → rp = 0.5 * 10k = 5000Ω (linear taper B)
*   HF_Atten = 0.0  → rp = 10Ω
*
* Switched-cap values (frozen at position 0 = index 0):
*   CPS     = 100n  (0.1u → 20 Hz LF corner)
*   KCS     = 5600p (5.6n → ~3.1 kHz HF boost tank)
*   HFA_sel = 3300p (3.3n → ~5 kHz HF atten corner)
*
* Source: R_in = 600Ω. Load: R_load = 100k. Output node: v_out.
* ============================================================================

* Source impedance
Rin   v_in   n_lf   600

* ── LOW FREQUENCY shelf ──────────────────────────────────────────────────────
Llf   n_lf   n_lb   2H
* LF_Boost at 0.0: rp = 10Ω
R_lfboost  n_lb  0  10

Ccps  n_lf   n_la   100n
* LF_Atten at 0.0: rp = 10Ω
R_lfatten  n_la  0  10

* Series bridge to HF section
Rlf   n_lf   n_hf   56k

* ── HIGH FREQUENCY BOOST section ─────────────────────────────────────────────
Lhf   n_hf   n_hfb  47m
Ckcs  n_hf   n_hfb  5600p
* HF_Boost at 0.0: rp = 10Ω
R_hfboost  n_hfb  0  10

* HF_BW at 0.5 (linear taper): rp = 0.5 * 10k = 5000Ω
R_hfbw  n_hf  0  5000

* ── HIGH FREQUENCY ATTEN shelf ───────────────────────────────────────────────
Chfas  n_hf   n_hfa_sw  3300p
* HF_Atten at 0.0: rp = 10Ω
R_hfatten  n_hfa_sw  0  10

* Bridge to output
Rhfa  n_hf   v_out   100k

* Output load
Rload  v_out  0  100k
