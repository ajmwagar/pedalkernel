* ============================================================================
* XREF Feedback Amp — MINIMAL MultiNl reproducer — faithful twin of
* circuits/active/xref_feedback_dc.pedal.
* 2-BJT shunt-feedback gain block. Only cap is Cf (the reactive port in the
* feedback loop, which forces the MultiNl/R-type path). Rf closes the loop AND
* DC-biases Q1. +24 V rail, input grounded for .op. Cf is open at DC so the
* operating point is purely resistive; b_passive(Cf) = v(nout) − v(nb1).
* ============================================================================
VCC   vcc   0     DC 24
Vin   ni    0     DC 0

Rin   ni    nb1   2.2k
Rf    nout  nb1   33k
Cf    nout  nb1   100p

RC1   vcc   nc1   10k
Q1    nc1   nb1   ne1   2N3904
RE1   ne1   0     1k

RC2   vcc   nout  4.7k
Q2    nout  nc1   ne2   2N3904
RE2   ne2   0     1k

RL    nout  0     10k

.MODEL 2N3904 NPN(IS=6.734f BF=416.4 BR=0.7371 NF=1.0 NR=1.0 VAF=74.03 VAR=28.0
+ IKF=66.78m IKR=10m ISE=6.734f NE=1.259 ISC=0 NC=2.0 RB=10 RE=0.1 RC=1
+ CJE=4.493p VJE=0.7 MJE=0.2593 CJC=3.638p VJC=0.75 MJC=0.2593 TF=301.2p TR=24n)

.control
op
print v(nb1) v(nc1) v(ne1) v(nout) v(ne2)
.endc
.end
